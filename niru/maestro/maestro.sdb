ADE simulation setup
Run mode: Single Run, Sweeps and Corners
Tests:
  DvlsiProject:niru:1: DvlsiProject/niru/schematic, simulator spectre
Corners:
  C0: temperature=27
  C1: temperature=-40 27 75 125
