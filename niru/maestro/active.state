ADE simulation setup
Test DvlsiProject:niru:1: DvlsiProject/niru/schematic, simulator spectre
  Models: /home/work/gpdk045_v_5_0/gpdk045/../models/spectre/gpdk045.scs[tt]
  Temperature: 27
  Analysis tran: stop=80n  errpreset=moderate
  Analysis dc: sweep /V1.dc start=0 stop=1.8 step=0.01 (saves the operating point)
  Signals: /A, /Y, /V0/MINUS (terminal)
Run mode: Single Run, Sweeps and Corners
Corners:
  C0: temperature=27
  C1: temperature=-40 27 75 125
