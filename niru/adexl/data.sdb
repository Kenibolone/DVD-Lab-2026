ADE simulation setup
Run mode: Single Run, Sweeps and Corners
Tests:
  DvlsiProject:niru:1: DvlsiProject/niru/schematic, simulator spectre
